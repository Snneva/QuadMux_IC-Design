* NGSPICE file created from TG.ext - technology: sky130A

.subckt TG IN OUT S_bar S VDD GND
X0 OUT S IN GND sky130_fd_pr__nfet_01v8 ad=0.2375 pd=1.95 as=0.2375 ps=1.95 w=0.5 l=0.15
X1 OUT S_bar IN VDD sky130_fd_pr__pfet_01v8 ad=0.2375 pd=1.95 as=0.2375 ps=1.95 w=0.5 l=0.15
.ends
